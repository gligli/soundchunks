* C:\soundchunks\decoder_atari_ste\tools\spice\lmc1992_bass_treb.asc
* Generated by LTspice 26.0.2 for Windows.
R1 N007 IN 116.4k
R2 N003 N008 116.4k
R3 N004 N001 2.6k
R4 N002 N005 2.6k
X§Ptreb N004 N005 N006 potentiometer Rtot=11.4K wiper=#treb# ;§pnba A)B)C
X§Pbass N007 N008 N006 potentiometer Rtot=509.2K wiper=#bass# ;§pnba A)B)C
C1 N001 IN 0.0082µ
C2 N003 N002 0.0082µ
X§Pout N003 0 OUT potentiometer Rtot=10K wiper=1 ;§pnba A)B)C
V1 N009 0 4.1
V2 0 N010 4.1
V3 IN 0 AC 1
X§U1 0 N006 N009 N010 N003 TL082 ;§pnba In+)In-)V+)V-)OUT
.ac oct 240 1 25033.16667
* Library below included based on ModelFile attribute of instance X§Ptreb, X§Pbass, X§Pout (C:\soundchunks\decoder_atari_ste\tools\spice\potentiometer.asy)
.lib potentiometer.sub
* Library below included based on ModelFile attribute of instance X§U1 (C:\soundchunks\decoder_atari_ste\tools\spice\TL082.asy)
.lib TL082.sub
.backanno
.end
